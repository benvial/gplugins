* `circuit.Package` `gplugins.klayout.example`
* Generated by `vlsirtools.SpiceNetlister`
*

.SUBCKT taper_gdsfactorypcompon_e6a63921
+ 1
* No parameters

.ENDS

.SUBCKT pad_gdsfactorypcomponen_457de54c
+ 1 2
* No parameters

.ENDS

.SUBCKT pads_correct_Ppad_CSmetal3
* No ports
* No parameters

x1
+ tl,tr tl
+ pad_gdsfactorypcomponen_457de54c
* No parameters

x2
+ tl,tr
+ taper_gdsfactorypcompon_e6a63921
* No parameters

x3
+ tl,tr tr
+ pad_gdsfactorypcomponen_457de54c
* No parameters

x4
+ tl,tr
+ taper_gdsfactorypcompon_e6a63921
* No parameters

x5
+ bl,br br
+ pad_gdsfactorypcomponen_457de54c
* No parameters

x6
+ bl,br bl
+ pad_gdsfactorypcomponen_457de54c
* No parameters

x7
+ bl,br
+ taper_gdsfactorypcompon_e6a63921
* No parameters

x8
+ bl,br
+ taper_gdsfactorypcompon_e6a63921
* No parameters

.ENDS
