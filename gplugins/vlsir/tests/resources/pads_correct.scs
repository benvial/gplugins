// `circuit.Package` `gplugins.klayout.example`
// Generated by `vlsirtools.SpectreNetlister`
//

subckt taper_gdsfactorypcompon_e6a63921
  + 1
  + // No parameters

ends

subckt pad_gdsfactorypcomponen_457de54c
  + 1 2
  + // No parameters

ends

subckt pads_correct_Ppad_CSmetal3
  + // No ports
  + // No parameters

  1
  + // Ports:
  + ( tl,tr tl )
  +  pad_gdsfactorypcomponen_457de54c
  + // No parameters

  2
  + // Ports:
  + ( tl,tr )
  +  taper_gdsfactorypcompon_e6a63921
  + // No parameters

  3
  + // Ports:
  + ( tl,tr tr )
  +  pad_gdsfactorypcomponen_457de54c
  + // No parameters

  4
  + // Ports:
  + ( tl,tr )
  +  taper_gdsfactorypcompon_e6a63921
  + // No parameters

  5
  + // Ports:
  + ( bl,br br )
  +  pad_gdsfactorypcomponen_457de54c
  + // No parameters

  6
  + // Ports:
  + ( bl,br bl )
  +  pad_gdsfactorypcomponen_457de54c
  + // No parameters

  7
  + // Ports:
  + ( bl,br )
  +  taper_gdsfactorypcompon_e6a63921
  + // No parameters

  8
  + // Ports:
  + ( bl,br )
  +  taper_gdsfactorypcompon_e6a63921
  + // No parameters

ends
